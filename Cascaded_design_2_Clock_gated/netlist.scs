// Design: Haneesh_1/Cascaded_design_2_Clock_gated
simulator lang=spectre
global 0
//include "/home/install/FOUNDRY/analog/45nm/gpdk045/../models/spectre/gpdk045.scs" section=mc

// Haneesh_1/inverter/schematic
subckt inverter Vdd Vin Vout Vss
    PM0 (Vout Vin Vdd Vdd) g45p1svt w=(170n) l=45n nf=1 m=(1)
    NM0 (Vout Vin Vss Vss) g45n1svt w=(120n) l=45n nf=1 m=(1)
ends inverter

// Haneesh_1/2_ip_AND/schematic
subckt Haneesh_1_2_ip_AND_schematic A B Vdd Vout Vss
    PM2 (Vout net1 Vdd Vdd) g45p1svt w=(170n) l=45n nf=1 m=(1)
    PM1 (net1 B Vdd Vdd) g45p1svt w=(120n) l=45n nf=1 m=(1)
    PM0 (net1 A Vdd Vdd) g45p1svt w=(120n) l=45n nf=1 m=(1)
    NM2 (Vout net1 Vss Vss) g45n1svt w=(120n) l=45n nf=1 m=(1)
    NM1 (net2 B Vss Vss) g45n1svt w=(170n) l=45n nf=1 m=(1)
    NM0 (net1 A net2 Vss) g45n1svt w=(170n) l=45n nf=1 m=(1)
ends Haneesh_1_2_ip_AND_schematic

// Haneesh_1/3_ip_AND/schematic
subckt Haneesh_1_3_ip_AND_schematic A B C Vdd Vout Vss
    PM3 (Vout net2 Vdd Vdd) g45p1svt w=(170n) l=45n nf=1 m=(1)
    PM2 (net2 C Vdd Vdd) g45p1svt w=(120n) l=45n nf=1 m=(1)
    PM1 (net2 B Vdd Vdd) g45p1svt w=(120n) l=45n nf=1 m=(1)
    PM0 (net2 A Vdd Vdd) g45p1svt w=(120n) l=45n nf=1 m=(1)
    NM3 (Vout net2 Vss Vss) g45n1svt w=(120n) l=45n nf=1 m=(1)
    NM2 (net6 C Vss Vss) g45n1svt w=(260n) l=45n nf=1 m=(1)
    NM1 (net5 B net6 Vss) g45n1svt w=(260n) l=45n nf=1 m=(1)
    NM0 (net2 A net5 Vss) g45n1svt w=(260n) l=45n nf=1 m=(1)
ends Haneesh_1_3_ip_AND_schematic

// Haneesh_1/Cascaded_design_2_Clock_gated/schematic
I3 (Vdd D Dbar Vss) inverter
I2 (Vdd C Cbar Vss) inverter
I1 (Vdd B Bbar Vss) inverter
I0 (Vdd A Abar Vss) inverter
I53 (C D Vdd net4 Vss) Haneesh_1_2_ip_AND_schematic
I52 (A B Vdd net1 Vss) Haneesh_1_2_ip_AND_schematic
I50 (C Dbar Vdd net8 Vss) Haneesh_1_2_ip_AND_schematic
I49 (A B Vdd net7 Vss) Haneesh_1_2_ip_AND_schematic
I47 (Cbar D Vdd net74 Vss) Haneesh_1_2_ip_AND_schematic
I46 (A B Vdd net71 Vss) Haneesh_1_2_ip_AND_schematic
I44 (Cbar Dbar Vdd net68 Vss) Haneesh_1_2_ip_AND_schematic
I43 (A B Vdd net65 Vss) Haneesh_1_2_ip_AND_schematic
I41 (C D Vdd net62 Vss) Haneesh_1_2_ip_AND_schematic
I40 (A Bbar Vdd net59 Vss) Haneesh_1_2_ip_AND_schematic
I38 (C Dbar Vdd net56 Vss) Haneesh_1_2_ip_AND_schematic
I37 (A Bbar Vdd net53 Vss) Haneesh_1_2_ip_AND_schematic
I35 (Cbar D Vdd net50 Vss) Haneesh_1_2_ip_AND_schematic
I34 (A Bbar Vdd net47 Vss) Haneesh_1_2_ip_AND_schematic
I32 (Cbar Dbar Vdd net44 Vss) Haneesh_1_2_ip_AND_schematic
I31 (A Bbar Vdd net41 Vss) Haneesh_1_2_ip_AND_schematic
I29 (C D Vdd net38 Vss) Haneesh_1_2_ip_AND_schematic
I28 (Abar B Vdd net35 Vss) Haneesh_1_2_ip_AND_schematic
I26 (C Dbar Vdd net32 Vss) Haneesh_1_2_ip_AND_schematic
I25 (Abar B Vdd net29 Vss) Haneesh_1_2_ip_AND_schematic
I23 (Cbar D Vdd net26 Vss) Haneesh_1_2_ip_AND_schematic
I22 (Abar B Vdd net23 Vss) Haneesh_1_2_ip_AND_schematic
I20 (Cbar Dbar Vdd net20 Vss) Haneesh_1_2_ip_AND_schematic
I19 (Abar B Vdd net17 Vss) Haneesh_1_2_ip_AND_schematic
I17 (C D Vdd net13 Vss) Haneesh_1_2_ip_AND_schematic
I16 (Abar Bbar Vdd net10 Vss) Haneesh_1_2_ip_AND_schematic
I14 (C Dbar Vdd net9 Vss) Haneesh_1_2_ip_AND_schematic
I13 (Abar Bbar Vdd net16 Vss) Haneesh_1_2_ip_AND_schematic
I11 (Cbar D Vdd net90 Vss) Haneesh_1_2_ip_AND_schematic
I10 (Abar Bbar Vdd net87 Vss) Haneesh_1_2_ip_AND_schematic
I5 (Cbar Dbar Vdd net84 Vss) Haneesh_1_2_ip_AND_schematic
I4 (Abar Bbar Vdd net81 Vss) Haneesh_1_2_ip_AND_schematic
I54 (net1 net4 clk Vdd Y\<15\> Vss) Haneesh_1_3_ip_AND_schematic
I51 (net7 net8 clk Vdd Y\<14\> Vss) Haneesh_1_3_ip_AND_schematic
I48 (net71 net74 clk Vdd Y\<13\> Vss) Haneesh_1_3_ip_AND_schematic
I45 (net65 net68 clk Vdd Y\<12\> Vss) Haneesh_1_3_ip_AND_schematic
I42 (net59 net62 clk Vdd Y\<11\> Vss) Haneesh_1_3_ip_AND_schematic
I39 (net53 net56 clk Vdd Y\<10\> Vss) Haneesh_1_3_ip_AND_schematic
I36 (net47 net50 clk Vdd Y\<9\> Vss) Haneesh_1_3_ip_AND_schematic
I33 (net41 net44 clk Vdd Y\<8\> Vss) Haneesh_1_3_ip_AND_schematic
I30 (net35 net38 clk Vdd Y\<7\> Vss) Haneesh_1_3_ip_AND_schematic
I27 (net29 net32 clk Vdd Y\<6\> Vss) Haneesh_1_3_ip_AND_schematic
I24 (net23 net26 clk Vdd Y\<5\> Vss) Haneesh_1_3_ip_AND_schematic
I21 (net17 net20 clk Vdd Y\<4\> Vss) Haneesh_1_3_ip_AND_schematic
I18 (net10 net13 clk Vdd Y\<3\> Vss) Haneesh_1_3_ip_AND_schematic
I15 (net16 net9 clk Vdd Y\<2\> Vss) Haneesh_1_3_ip_AND_schematic
I12 (net87 net90 clk Vdd Y\<1\> Vss) Haneesh_1_3_ip_AND_schematic
I6 (net81 net84 clk Vdd Y\<0\> Vss) Haneesh_1_3_ip_AND_schematic
simulatorOptions options temp=25 tnom=25
//modelParameter info what=models where=rawfile
//element info what=inst where=rawfile
//outputParameter info what=output where=rawfile
//designParamVals info what=parameters where=rawfile
//primitives info what=primitives where=rawfile
//subckts info what=subckts where=rawfile
