// Design: Haneesh_1/Cascaded_design_2
simulator lang=spectre
global 0
//include "/home/install/FOUNDRY/analog/45nm/gpdk045/../models/spectre/gpdk045.scs" section=mc

// Haneesh_1/inverter/schematic
subckt inverter Vdd Vin Vout Vss
    PM0 (Vout Vin Vdd Vdd) g45p1svt w=(170n) l=45n nf=1 m=(1)
    NM0 (Vout Vin Vss Vss) g45n1svt w=(120n) l=45n nf=1 m=(1)
ends inverter

// Haneesh_1/2_ip_AND/schematic
subckt Haneesh_1_2_ip_AND_schematic A B Vdd Vout Vss
    PM2 (Vout net1 Vdd Vdd) g45p1svt w=(170n) l=45n nf=1 m=(1)
    PM1 (net1 B Vdd Vdd) g45p1svt w=(120n) l=45n nf=1 m=(1)
    PM0 (net1 A Vdd Vdd) g45p1svt w=(120n) l=45n nf=1 m=(1)
    NM2 (Vout net1 Vss Vss) g45n1svt w=(120n) l=45n nf=1 m=(1)
    NM1 (net2 B Vss Vss) g45n1svt w=(170n) l=45n nf=1 m=(1)
    NM0 (net1 A net2 Vss) g45n1svt w=(170n) l=45n nf=1 m=(1)
ends Haneesh_1_2_ip_AND_schematic

// Haneesh_1/Cascaded_design_2/schematic
I3 (Vdd D Dbar Vss) inverter
I2 (Vdd C Cbar Vss) inverter
I1 (Vdd B Bbar Vss) inverter
I0 (Vdd A Abar Vss) inverter
I51 (net7 net8 Vdd Y\<15\> Vss) Haneesh_1_2_ip_AND_schematic
I50 (C D Vdd net8 Vss) Haneesh_1_2_ip_AND_schematic
I49 (A B Vdd net7 Vss) Haneesh_1_2_ip_AND_schematic
I48 (net5 net6 Vdd Y\<14\> Vss) Haneesh_1_2_ip_AND_schematic
I47 (C Dbar Vdd net6 Vss) Haneesh_1_2_ip_AND_schematic
I46 (A B Vdd net5 Vss) Haneesh_1_2_ip_AND_schematic
I45 (net3 net4 Vdd Y\<13\> Vss) Haneesh_1_2_ip_AND_schematic
I44 (Cbar D Vdd net4 Vss) Haneesh_1_2_ip_AND_schematic
I43 (A B Vdd net3 Vss) Haneesh_1_2_ip_AND_schematic
I42 (net1 net2 Vdd Y\<12\> Vss) Haneesh_1_2_ip_AND_schematic
I41 (Cbar Dbar Vdd net2 Vss) Haneesh_1_2_ip_AND_schematic
I40 (A B Vdd net1 Vss) Haneesh_1_2_ip_AND_schematic
I39 (net15 net16 Vdd Y\<11\> Vss) Haneesh_1_2_ip_AND_schematic
I38 (C D Vdd net16 Vss) Haneesh_1_2_ip_AND_schematic
I37 (A Bbar Vdd net15 Vss) Haneesh_1_2_ip_AND_schematic
I36 (net13 net14 Vdd Y\<10\> Vss) Haneesh_1_2_ip_AND_schematic
I35 (C Dbar Vdd net14 Vss) Haneesh_1_2_ip_AND_schematic
I34 (A Bbar Vdd net13 Vss) Haneesh_1_2_ip_AND_schematic
I33 (net11 net12 Vdd Y\<9\> Vss) Haneesh_1_2_ip_AND_schematic
I32 (Cbar D Vdd net12 Vss) Haneesh_1_2_ip_AND_schematic
I31 (A Bbar Vdd net11 Vss) Haneesh_1_2_ip_AND_schematic
I30 (net9 net10 Vdd Y\<8\> Vss) Haneesh_1_2_ip_AND_schematic
I29 (Cbar Dbar Vdd net10 Vss) Haneesh_1_2_ip_AND_schematic
I28 (A Bbar Vdd net9 Vss) Haneesh_1_2_ip_AND_schematic
I27 (net25 net26 Vdd Y\<7\> Vss) Haneesh_1_2_ip_AND_schematic
I26 (C D Vdd net26 Vss) Haneesh_1_2_ip_AND_schematic
I25 (Abar B Vdd net25 Vss) Haneesh_1_2_ip_AND_schematic
I24 (net23 net24 Vdd Y\<6\> Vss) Haneesh_1_2_ip_AND_schematic
I23 (C Dbar Vdd net24 Vss) Haneesh_1_2_ip_AND_schematic
I22 (Abar B Vdd net23 Vss) Haneesh_1_2_ip_AND_schematic
I21 (net21 net22 Vdd Y\<5\> Vss) Haneesh_1_2_ip_AND_schematic
I20 (Cbar D Vdd net22 Vss) Haneesh_1_2_ip_AND_schematic
I19 (Abar B Vdd net21 Vss) Haneesh_1_2_ip_AND_schematic
I18 (net19 net20 Vdd Y\<4\> Vss) Haneesh_1_2_ip_AND_schematic
I17 (Cbar Dbar Vdd net20 Vss) Haneesh_1_2_ip_AND_schematic
I16 (Abar B Vdd net19 Vss) Haneesh_1_2_ip_AND_schematic
I15 (net17 net18 Vdd Y\<3\> Vss) Haneesh_1_2_ip_AND_schematic
I14 (C D Vdd net18 Vss) Haneesh_1_2_ip_AND_schematic
I13 (Abar Bbar Vdd net17 Vss) Haneesh_1_2_ip_AND_schematic
I12 (net31 net32 Vdd Y\<2\> Vss) Haneesh_1_2_ip_AND_schematic
I11 (C Dbar Vdd net32 Vss) Haneesh_1_2_ip_AND_schematic
I10 (Abar Bbar Vdd net31 Vss) Haneesh_1_2_ip_AND_schematic
I9 (net29 net30 Vdd Y\<1\> Vss) Haneesh_1_2_ip_AND_schematic
I8 (Cbar D Vdd net30 Vss) Haneesh_1_2_ip_AND_schematic
I7 (Abar Bbar Vdd net29 Vss) Haneesh_1_2_ip_AND_schematic
I6 (net27 net28 Vdd Y\<0\> Vss) Haneesh_1_2_ip_AND_schematic
I5 (Cbar Dbar Vdd net28 Vss) Haneesh_1_2_ip_AND_schematic
I4 (Abar Bbar Vdd net27 Vss) Haneesh_1_2_ip_AND_schematic
simulatorOptions options temp=25 tnom=25
//modelParameter info what=models where=rawfile
//element info what=inst where=rawfile
//outputParameter info what=output where=rawfile
//designParamVals info what=parameters where=rawfile
//primitives info what=primitives where=rawfile
//subckts info what=subckts where=rawfile
